* Op-Amp Design  Two-Stage Miller
* Simulator: NGspice 42+
* Generated by Tattva Silicon - Mixed Signal Analog Circuit Designer
* Gain=68.9dB, GBW=10MHz, PM=84.9

* --- PDK MODEL INCLUDE ---
.lib /Users/klonikar/.volare/gf180mcuC/libs.tech/ngspice/sm141064.ngspice typical

* --- 1. GLOBAL PARAMETERS & MEASUREMENT THRESHOLDS ---
.param VDD = 1.8
.param VICM = 0.9
.param vdd = 1.8
.param vicm = 0.9

* Pre-calculate Voltage Thresholds for .meas statements (Moved out of .control)
.param v10 = {0.1 * VDD}
.param v30 = {0.3 * VDD}
.param v70 = {0.7 * VDD}
.param v90 = {0.9 * VDD}
.param v99 = {0.99 * VDD}

* Global PDK Switches
.param fnoicor = 0
.param sw_et = 0

* --- 2. POWER SUPPLIES & STIMULI ---
VDD vdd 0 DC {VDD}
VSS vss 0 DC 0

* Input Stimulus for AC Analysis
VIN+ vin_p 0 DC {VICM} AC 0.5
VIN- vin_n 0 DC {VICM} AC -0.5

* Input Stimulus for Transient / Harmonic Analysis
VIN_SIN vin_sin 0 DC {VICM} SIN({VICM} 0.72 1k)
VIN_LS  vin_ls  0 PULSE(0 {VDD} 1u 1n 1n 5u 10u)

* Biasing Current Source
I_bias vdd vbias DC 55.6u

* --- 3. CIRCUIT INSTANTIATION (BINNED PRIMITIVES) ---
* M_bias: L=0.36u, W=9.36u maps to Bin 8
M_bias vbias vbias vss vss nfet_03v3.8

* Stage 1: Differential Pair with Active Load
M1 vout1 vin_p vtail vss nfet_03v3.8
M2 vx    vin_n vtail vss nfet_03v3.8
M3 vout1 vout1 vdd   vdd pfet_03v3.12
M4 vx    vout1 vdd   vdd pfet_03v3.12
M5 vtail vbias vss   vss nfet_03v3.12

* Stage 2: Common Source Stage
M6 vout  vx    vdd   vdd pfet_03v3.12
M7 vout  vbias vss   vss nfet_03v3.12

* Compensation Network
Cc vx vout 11.11p
Rz vx n_rz 1.43k

* Output Load Capacitance
CL vout 0 1p

* --- 4. SIMULATION COMMANDS (MAIN DECK) ---
.op
.ac DEC 10 10 100meg
.tran 1n 10m

* --- 6. INTERACTIVE CONTROL BLOCK ---
.control
  * 'run' automatically executes the .op, .ac, and .tran blocks defined above
  run

  * Perform Fourier / THD Analysis on the transient output
  fourier 1k v(vout)

  * --- Automated Measurement Extractions ---
  meas TRAN t30_r WHEN V(vout)={v30} RISE=1
  meas TRAN t70_r WHEN V(vout)={v70} RISE=1
  meas TRAN t70_f WHEN V(vout)={v70} FALL=1
  meas TRAN t30_f WHEN V(vout)={v30} FALL=1

  * Calculate Slew Rate Slopes (dV/dt)
  * meas TRAN slew_rise PARAM={(v70-v30)/(t70_r-t30_r)}
  * meas TRAN slew_fall PARAM={(v70-v30)/(t30_f-t70_f)}
  meas TRAN slew_rise param = ' (v70 - v30) / (t70_r - t30_r) '
  meas TRAN slew_fall param = ' (v70 - v30) / (t30_f - t70_f) '

  * Other transient metrics
  meas TRAN overshoot MAX V(vout) FROM=1u TO=6u
  meas TRAN settling_1pct WHEN V(vout)={v99} RISE=1
  * Destroy only the multidimensional fourier matrix
  * destroy tran1.fourier11
  * Alternatively, clear all fourier variables if multiple exist
  destroy fourier*
  * Save data vectors
  write output.raw v(vout)
.endc

.end
