* Op-Amp Design  Two-Stage Miller
* Generated by Tattva Silicon - Mixed Signal Analog Circuit Designer
* Gain=68.9dB, GBW=10MHz, PM=84.9

.param VDD = 1.8
.param VICM = 0.9

* Supply
VDD vdd 0 DC {VDD}
VSS vss 0 DC 0

* Biasing
I_bias vdd vbias DC 55.6u
M_bias vbias vbias vss vss NMOS W=9.36u L=0.36u

* Input Stimulus
VIN+ vin_p 0 DC {VICM} AC 0.5
VIN- vin_n 0 DC {VICM} AC -0.5

* Stage 1: Differential Pair with Active Load
M1 vout1 vin_p vtail vss NMOS W=4.41u L=0.18u
M2 vx    vin_n vtail vss NMOS W=4.41u L=0.18u
M3 vout1 vout1 vdd vdd PMOS W=40u L=0.36u
M4 vx    vout1 vdd vdd PMOS W=40u L=0.36u
M5 vtail vbias vss vss NMOS W=37.43u L=0.36u

* Stage 2: Common Source
M6 vout  vx    vdd vdd PMOS W=12.57u L=0.18u
M7 vout  vbias vss vss NMOS W=11.76u L=0.36u

* Compensation
Cc vx vout 11.11p
Rz vx n_rz 1.43k

* Load
CL vout 0 1p

*  Small-Signal AC Analysis
.op
.ac DEC 20 1 10G

*  Large-Signal Step Response (Slew Rate Test)
* Unity-gain buffer configuration: rail-to-rail input step
VIN_LS vin_ls 0 PULSE(0 {VDD} 1u 1n 1n 5u 10u)
* Feedback: connect output to inverting input for buffer
* E_buf vout_ls 0 vin_ls vout_ls 1e5
.tran 1n 20u

*  THD Measurement (Sinusoidal Input)
* SIN source at 1kHz for harmonic distortion analysis
VIN_SIN vin_sin 0 DC {VICM} SIN({VICM} 0.72 1k)
.FOUR 1k V(vout)

*  .MEAS Statements for Automated Metric Extraction
.MEAS TRAN slew_rise DERIV V(vout) WHEN V(vout)='0.3*{VDD}' RISE=1
.MEAS TRAN slew_fall DERIV V(vout) WHEN V(vout)='0.7*{VDD}' FALL=1
.MEAS TRAN t_rise TRIG V(vout) VAL='0.1*{VDD}' RISE=1 TARG V(vout) VAL='0.9*{VDD}' RISE=1
.MEAS TRAN t_fall TRIG V(vout) VAL='0.9*{VDD}' FALL=1 TARG V(vout) VAL='0.1*{VDD}' FALL=1
.MEAS TRAN overshoot MAX V(vout) FROM=1u TO=6u
.MEAS TRAN settling_1pct WHEN V(vout)='0.99*{VDD}' RISE=1

*
* Model Cards: 180nm Generic CMOS  |  Vt=SVT  Corner=TT  T=27C
* Generated by Tattva Silicon SPICE Model Generator
*
.model NMOS NMOS LEVEL=14
* BSIM4 v4.8  180nm Generic CMOS NMOS (derived from PDK provider)
+VERSION = 4.8     BINUNIT = 1      PARAMCHK= 1
+MOBMOD  = 0       CAPMOD  = 2      IGCMOD  = 1
+IGBMOD  = 1       GEOMOD  = 1      DIOMOD  = 1
+RDSMOD  = 0       RBODYMOD= 1      RGATEMOD= 1
+PERMOD  = 1       ACNQSMOD= 0      TRNQSMOD= 0
+FNOIFLG = 1       FNOIMOD = 1      TNOIMOD = 0
*
*  Threshold & Body Effect
+TOXE    = 6.366e-9    TOXP    = 6.047e-9    TOXM    = 6.366e-9
+DTOX    = 3.183e-10
+EPSROX  = 3.9
+VTH0    = 0.5000
+K1      = 0.5500         K2      = -0.0800
+K3      = 80              K3B     = 0
+W0      = 0               LPE0    = 0
+DVTP0   = 0.00e+0    DVTP1   = 0.000
+VOFF    = -0.080
*
*  Mobility
+U0      = 350.0000
+UA      = 1.00e-9      UB      = 2.30e-18
+UC      = -4.60e-11
+EU      = 1.67
+VSAT    = 8.000e+4
+A0      = 1.0             AGS     = 0.20
+A1      = 0               A2      = 1.0
+B0      = 0               B1      = 0
*
*  Channel Length Modulation & DIBL
+PCLM    = 0.6000
+PDIBLC1 = 0.1200    PDIBLC2 = 0.0100
+PDIBLCB = 0              DROUT   = 0.56
+PSCBE1  = 4.240e+8    PSCBE2  = 1.000e-5
+PVAG    = 0.1
+ETA0    = 0.0400         ETAB    = -0.07
+DSUB    = 0.56
*
*  Subthreshold
+NFACTOR = 1.200
+CDSC    = 2.400e-4
+CDSCD   = 1.200e-4
+CDSCB   = 0
+CIT     = 0.000e+0
*
*  S/D Resistance
+RDSW    = 250.0
+PRWG    = 0               PRWB    = 0
+WR      = 1
*
*  Length/Width Offsets
+LINT    = 2.000e-8    WINT    = 5.000e-8
+DWG     = 0               DWB     = 0
+XL      = 0               XW      = 0
*
*  Noise
+NOIA    = 3.000e+3
+NOIB    = 1.500e+7
+NOIC    = -1.400e-12
+AF      = 1.00            EF      = 1.0
*
*  Temperature
+TNOM    = 27              UTE     = -1.50
+KT1     = -0.1500    KT1L    = 0
+KT2     = 0.022           AT      = 3.30e+4
*
*  Parasitic Capacitance
+CGSO    = 1.319e-13
+CGDO    = 1.319e-13
+CGBO    = 1.000e-12
+CJ      = 1.000e-3
+CJSW    = 5.000e-10
+MJ      = 0.5             MJSW    = 0.33
+PB      = 1.0             PBSW    = 1.0

.model PMOS PMOS LEVEL=14
* BSIM4 v4.8  180nm Generic CMOS PMOS (derived from PDK provider)
+VERSION = 4.8     BINUNIT = 1      PARAMCHK= 1
+MOBMOD  = 0       CAPMOD  = 2      IGCMOD  = 1
+IGBMOD  = 1       GEOMOD  = 1      DIOMOD  = 1
+RDSMOD  = 0       RBODYMOD= 1      RGATEMOD= 1
+PERMOD  = 1       ACNQSMOD= 0      TRNQSMOD= 0
+FNOIFLG = 1       FNOIMOD = 1      TNOIMOD = 0
*
*  Threshold & Body Effect
+TOXE    = 6.911e-9    TOXP    = 6.566e-9    TOXM    = 6.911e-9
+DTOX    = 3.456e-10
+EPSROX  = 3.9
+VTH0    = -0.5000
+K1      = 0.5500         K2      = -0.0800
+K3      = 80              K3B     = 0
+W0      = 0               LPE0    = 0
+DVTP0   = 0.00e+0    DVTP1   = 0.000
+VOFF    = -0.080
*
*  Mobility
+U0      = 35.0000
+UA      = 1.50e-9      UB      = 2.30e-18
+UC      = -3.00e-11
+EU      = 1.00
+VSAT    = 8.000e+4
+A0      = 1.0             AGS     = 0.30
+A1      = 0               A2      = 1.0
+B0      = 0               B1      = 0
*
*  Channel Length Modulation & DIBL
+PCLM    = 0.6000
+PDIBLC1 = 0.1200    PDIBLC2 = 0.0100
+PDIBLCB = 0              DROUT   = 0.56
+PSCBE1  = 4.240e+8    PSCBE2  = 1.000e-5
+PVAG    = 0.1
+ETA0    = 0.0400         ETAB    = -0.07
+DSUB    = 0.56
*
*  Subthreshold
+NFACTOR = 1.200
+CDSC    = 2.400e-4
+CDSCD   = 1.200e-4
+CDSCB   = 0
+CIT     = 0.000e+0
*
*  S/D Resistance
+RDSW    = 250.0
+PRWG    = 0               PRWB    = 0
+WR      = 1
*
*  Length/Width Offsets
+LINT    = 2.000e-8    WINT    = 5.000e-8
+DWG     = 0               DWB     = 0
+XL      = 0               XW      = 0
*
*  Noise
+NOIA    = 1.000e+4
+NOIB    = 5.000e+7
+NOIC    = -1.400e-12
+AF      = 1.00            EF      = 1.0
*
*  Temperature
+TNOM    = 27              UTE     = -1.50
+KT1     = -0.1500    KT1L    = 0
+KT2     = 0.022           AT      = 2.00e+4
*
*  Parasitic Capacitance
+CGSO    = 1.432e-13
+CGDO    = 1.432e-13
+CGBO    = 1.000e-12
+CJ      = 1.200e-3
+CJSW    = 6.000e-10
+MJ      = 0.5             MJSW    = 0.33
+PB      = 1.0             PBSW    = 1.0

.end
