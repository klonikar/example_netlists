.options behavior=lt
* PLL Block: PFD (Phase/Frequency Detector)
* Simulator: LTspice XVII
* Values sourced from PLL Design Workbench (same as Summary tab)
* N=50, Icp=1389 A, R1=6.351e+3 , C1=2.334e-10 F, C2=2.334e-11 F

.param vdd = 1.8
.param fref = 2.0000e+7
Vref ref 0 PULSE(0 {vdd} 0 100p 100p {0.5/fref} {1/fref})
.param phase_err=0.05
Vfb  fb  0 PULSE(0 {vdd} {phase_err/fref} 100p 100p {0.5/fref} {1/fref})

* Tri-state PFD  behavioral B-sources
BUP up 0 V = {V(ref)>{vdd/2} & V(dn)<{vdd/2} ? {vdd} : 0}
BDN dn 0 V = {V(fb)>{vdd/2} & V(up)<{vdd/2} ? {vdd} : 0}

.options reltol=1e-3 abstol=1e-12
.tran 100p {5/fref}

.end
